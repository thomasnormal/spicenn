* Behavioral multi-comparator thermometer activation.
* Generated copies replace THERM_EXPR with a sum of noisy comparisons.
.param VDD=0.8
.param S=0
.param SIGMA=1.5m
.param NT=100p
.param TSTOP=30n
.param TDECIDE=25n
.param SEED=1

Vs sig 0 DC {S}
Vn n 0 DC 0 TRNOISE({SIGMA} {NT} 0 0)

* out is a normalized multi-level code represented as 0..VDD.
Bcode out 0 V = {VDD} * (THERM_EXPR)

.tran 20p {TSTOP}
.meas tran y FIND V(out) AT={TDECIDE}

.control
setseed {SEED}
run
print y
.endc
.end
